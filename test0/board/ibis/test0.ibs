[IBIS Ver]   4.2
[File Name]  test0.ibs
[File Rev]   2.0
[Date]   February 17, 2024
[Source]   Altera Corporation
[Notes]   - The models are designated as "Correlated" and have been
   correlated against physical device operation.
   - This IBIS model is checked using IBISCHK v5.0.4
   There are no known errors and warnings reported.
   - There are no known limitations for this IBIS model release.
   - Contact point: Altera Corporation,
   http://www.altera.com/corporate/contact/con-index.html
   - This file is generated using Quartus II
   Version 23.1std.0 Build 991 11/28/2023 SC Lite Edition
   - Unused IOs which have been assigned as tri-stated inputs or
   as outputs driving any signal in Quartus II are represented by
   the NC.
   - Only general purpose IBIS models are supported.
   Revision History
   - v1.0
   - Initial Release of Cyclone V IBIS models
   - v2.0
   - Models have been correlated against physical device operation.
[Disclaimer] Data is for modeling purposes only and is not guaranteed.
[Copyright]  Copyright (C) 2023  Intel Corporation. All rights reserved.
[Component]  5CSXFC6D6F31C6_test0
[Manufacturer] Altera Corporation
[Package]
| RLC values are for 896 FBGA package
| variable  typ   min   max
R_pkg   641m   160m   1179m
L_pkg   5.84nH   1.67nH   9.92nH
C_pkg   1.56pF   0.53pF   3.01pF
[Pin]  signal_name   model_name   R_pin   L_pin   C_pin
A12   GND   GND
A17   GND   GND
A2   GND   GND
A22   GND   GND
A26   GND   GND
A27   GND   GND
A7   VCCIO8A   POWER
AA10   VCCPD3A   POWER
AA11   GND   GND
AA12   nRST   25_crpin
AA14   PB[2]   25_crpin
AA15   PB[3]   25_crnin
AA17   VCCIO4A   POWER
AA18   SS[2][2]   25_crnio_r50
AA19   SS[3][5]   25_crnio_r50
AA20   SS[3][3]   25_crnio_r50
AA21   SS[2][0]   25_crpio_r50
AA22   GND   GND
AA23   VCCPGM   POWER
AA24   LEDR[0]   25_rrpio_r50
AA27   VCCIO5B   POWER
AA29   VREFB5BN0   POWER
AA3   GND   GND
AA30   SW[9]   25_rrnin
AA4   GND   GND
AA5   VCCE_GXBL   POWER
AA6   GND   GND
AA8   VCCA_FPLL   POWER
AA9   GND   GND
AB1   GND   GND
AB10   VCCPGM   POWER
AB11   VCC_AUX   POWER
AB12   SS[5][7]   25_crnio_r50
AB14   VCCIO3B   POWER
AB16   VCC_AUX   POWER
AB17   SS[2][1]   25_crnio_r50
AB18   VCCPD3B4A   POWER
AB19   GND   GND
AB2   GND   GND
AB20   VCCPD3B4A   POWER
AB21   SS[5][6]   25_crnio_r50
AB22   LEDR[8]   25_rrpio_r50
AB23   LEDR[1]   25_rrnio_r50
AB24   VCCIO5A   POWER
AB28   SW[2]   25_rtpin
AB29   GND   GND
AB30   SW[0]   25_rrpin
AB5   GND   GND
AB6   VCCH_GXBL   POWER
AB7   GND   GND
AC10   VCCPD3A   POWER
AC11   VCCIO3A   POWER
AC12   SS[4][7]   25_crpio_r50
AC13   VCCPD3B4A   POWER
AC15   VCCPD3B4A   POWER
AC16   GND   GND
AC17   VCCPD3B4A   POWER
AC19   VCCPD3B4A   POWER
AC20   SS[3][4]   25_crpio_r50
AC21   VCCIO4A   POWER
AC22   LEDR[9]   25_crpio_r50
AC23   LEDR[2]   25_crnio_r50
AC24   VREFB5AN0   POWER
AC26   GND   GND
AC28   SW[6]   25_rtpin
AC29   SW[8]   25_rtnin
AC3   GND   GND
AC30   SW[3]   25_rtnin
AC4   GND   GND
AC6   GND   GND
AC8   GND   GND
AC9   SS[3][7]   25_crpio_r50
AD1   GND   GND
AD10   SS[0][7]   25_crnio_r50
AD11   SS[1][7]   25_crpio_r50
AD12   SS[2][7]   25_crnio_r50
AD13   VCCIO3B   POWER
AD16   VCCPD3B4A   POWER
AD17   SS[1][3]   25_crnio_r50
AD18   VCCIO4A   POWER
AD19   SS[3][2]   25_crnio_r50
AD2   GND   GND
AD20   SS[3][6]   25_crpio_r50
AD21   SS[4][0]   25_crnio_r50
AD22   VCC_AUX   POWER
AD23   GND   GND
AD24   LEDR[3]   25_ctpio_r50
AD28   VCCIO5A   POWER
AD30   SW[7]   25_rtpin
AD5   GND   GND
AD6   VREFB3AN0   POWER
AD8   VCCIO3A   POWER
AE10   GND   GND
AE15   VCCIO3B   POWER
AE16   SS[1][2]   25_ctpio_r50
AE17   SS[1][5]   25_crpio_r50
AE18   SS[1][4]   25_crpio_r50
AE19   SS[5][4]   25_crnio_r50
AE20   GND   GND
AE21   VCCPD3B4A   POWER
AE22   SS[4][2]   25_crpio_r50
AE23   SS[4][3]   25_crnio_r50
AE24   LEDR[6]   25_ctnio_r50
AE25   VCCIO4A   POWER
AE3   GND   GND
AE30   VCCIO5B   POWER
AE4   GND   GND
AF1   GND   GND
AF12   GND   GND
AF14   CLK   25_crpin
AF16   SS[1][0]   25_ctnio_r50
AF17   GND   GND
AF18   SS[2][5]   25_crnio_r50
AF19   SS[5][5]   25_crpio_r50
AF2   GND   GND
AF20   SS[5][2]   25_crpio_r50
AF21   SS[5][0]   25_crnio_r50
AF22   VCCIO4A   POWER
AF23   SS[4][5]   25_crpio_r50
AF24   LEDR[7]   25_crnio_r50
AF25   LEDR[5]   25_ctpio_r50
AF27   GND   GND
AF3   GND   GND
AF7   VCCIO3A   POWER
AG14   GND   GND
AG16   SS[0][3]   25_ctpio_r50
AG17   SS[0][2]   25_ctnio_r50
AG18   SS[0][5]   25_ctpio_r50
AG19   VCCIO4A   POWER
AG20   SS[5][3]   25_crnio_r50
AG21   SS[5][1]   25_crpio_r50
AG22   SS[4][1]   25_ctpio_r50
AG23   SS[4][4]   25_ctpio_r50
AG24   GND   GND
AG25   LEDR[4]   25_ctpio_r50
AG29   VCCIO5A   POWER
AG4   VCCIO3A   POWER
AG9   GND   GND
AH1   GND   GND
AH11   GND   GND
AH16   VCCIO4A   POWER
AH17   SS[0][4]   25_ctpio_r50
AH18   SS[0][6]   25_ctnio_r50
AH21   GND   GND
AH22   SS[4][6]   25_ctnio_r50
AH26   VCCIO4A   POWER
AH6   GND   GND
AJ1   MSEL[4]   25_crpin
AJ13   VCCIO3B   POWER
AJ15   VREFB3BN0   POWER
AJ18   GND   GND
AJ23   VCCIO4A   POWER
AJ28   GND   GND
AJ3   GND   GND
AJ30   GND   GND
AJ4   PB[0]   25_ctpin
AJ8   VCCIO3B   POWER
AK10   VCCIO3B   POWER
AK15   GND   GND
AK17   VREFB4AN0   POWER
AK2   MSEL[1]   25_ctpin
AK20   VCCIO4A   POWER
AK25   GND   GND
AK3   MSEL[3]   25_ctnin
AK4   PB[1]   25_ctnin
AK5   GND   GND
B10   VREFB8AN0   POWER
B14   GND   GND
B19   GND   GND
B24   GND   GND
B29   GND   GND
B4   VCCIO8A   POWER
B9   GND   GND
C1   GND   GND
C11   VCCIO8A   POWER
C16   GND   GND
C21   GND   GND
C26   GND   GND
C6   GND   GND
D13   GND   GND
D18   VCCIO7C_HPS   POWER
D23   GND   GND
D26   GND   GND
D28   VCCIO6A_HPS   POWER
D3   GND   GND
D8   VCCIO8A   POWER
E10   GND   GND
E15   VCCIO7D_HPS   POWER
E20   VCCIO7B_HPS   POWER
E22   VREFB7A7B7C7DN0_HPS   POWER
E25   GND   GND
E30   GND   GND
E5   VCCIO8A   POWER
F12   VCCIO8A   POWER
F17   GND   GND
F2   GND   GND
F22   VCCIO7A_HPS   POWER
F27   GND   GND
F5   GND   GND
F7   GND   GND
G14   VCCIO8A   POWER
G19   VCCIO7B_HPS   POWER
G24   GND   GND
G29   VCCIO6A_HPS   POWER
G3   GND   GND
G4   GND   GND
G9   VCCIO8A   POWER
H1   GND   GND
H10   VCC_AUX   POWER
H11   GND   GND
H16   VCCIO7D_HPS   POWER
H2   GND   GND
H21   VCCIO7A_HPS   POWER
H26   VCCIO6A_HPS   POWER
H5   GND   GND
H6   VCCIO8A   POWER
H9   VCCBAT   POWER
J11   VCCPGM   POWER
J13   VCCIO8A   POWER
J16   VCC_AUX   POWER
J17   VCCPD7C_HPS   POWER
J18   GND   GND
J20   VCCRSTCLK_HPS   POWER
J21   VCC_AUX_SHARED   POWER
J22   GND   GND
J28   GND   GND
J3   GND   GND
J4   GND   GND
J6   GND   GND
J8   GND   GND
K1   GND   GND
K10   GND   GND
K11   VCCPD8A   POWER
K13   VCCPD8A   POWER
K15   GND   GND
K16   VCCPD7D_HPS   POWER
K18   VCCPD7B_HPS   POWER
K19   VCCPD7A_HPS   POWER
K2   GND   GND
K20   GND   GND
K24   VCCIO6A_HPS   POWER
K25   GND   GND
K30   VCCIO6A_HPS   POWER
K5   GND   GND
K9   VCCA_FPLL   POWER
L10   VCCPD8A   POWER
L11   GND   GND
L12   VCCPD8A   POWER
L13   GND   GND
L14   VCCPD8A   POWER
L15   GND   GND
L16   VCC_HPS   POWER
L17   GND   GND
L18   VCC_HPS   POWER
L19   GND   GND
L20   VCC_HPS   POWER
L21   VCCPLL_HPS   POWER
L22   GND   GND
L27   VCCIO6A_HPS   POWER
L3   GND   GND
L4   GND   GND
L5   VCCL_GXBL   POWER
L6   GND   GND
M1   GND   GND
M10   GND   GND
M11   VCC   POWER
M12   GND   GND
M13   VCC   POWER
M14   GND   GND
M15   VCC_HPS   POWER
M16   GND   GND
M18   GND   GND
M2   GND   GND
M20   GND   GND
M21   VCCPD6A6B_HPS   POWER
M24   VCCIO6A_HPS   POWER
M29   GND   GND
M5   GND   GND
M6   VCCE_GXBL   POWER
M7   GND   GND
M8   GND   GND
M9   VCC   POWER
N10   VCC   POWER
N11   GND   GND
N12   VCC   POWER
N13   GND   GND
N14   VCC   POWER
N15   GND   GND
N17   GND   GND
N19   GND   GND
N20   VCC_HPS   POWER
N21   VCCIO6A_HPS   POWER
N22   VCCPD6A6B_HPS   POWER
N26   GND   GND
N3   GND   GND
N4   GND   GND
N5   VCCE_GXBL   POWER
N6   GND   GND
N7   VCCA_FPLL   POWER
N8   GND   GND
N9   GND   GND
P1   GND   GND
P10   GND   GND
P11   VCC   POWER
P12   GND   GND
P13   VCC   POWER
P14   GND   GND
P15   VCC_HPS   POWER
P16   GND   GND
P17   VCC_HPS   POWER
P18   GND   GND
P19   VCC_HPS   POWER
P2   GND   GND
P20   GND   GND
P21   VCCPD6A6B_HPS   POWER
P23   VCCIO6B_HPS   POWER
P28   VCCIO6B_HPS   POWER
P5   GND   GND
P6   VCCH_GXBL   POWER
P7   GND   GND
R10   VCC   POWER
R11   GND   GND
R12   VCC   POWER
R13   GND   GND
R14   VCC   POWER
R15   GND   GND
R16   VCC_HPS   POWER
R17   GND   GND
R20   VCCPD6A6B_HPS   POWER
R23   VCCPD6A6B_HPS   POWER
R25   VCCIO6B_HPS   POWER
R3   GND   GND
R30   GND   GND
R4   GND   GND
R5   VCCL_GXBL   POWER
R6   GND   GND
R7   VCCA_FPLL   POWER
R8   GND   GND
R9   GND   GND
T1   GND   GND
T10   GND   GND
T11   VCC   POWER
T12   GND   GND
T13   VCC   POWER
T14   GND   GND
T15   GND   GND
T16   GND   GND
T17   VCC_HPS   POWER
T18   GND   GND
T19   VCC_HPS   POWER
T2   GND   GND
T20   GND   GND
T22   VCCIO6B_HPS   POWER
T27   GND   GND
T5   GND   GND
T6   VCCE_GXBL   POWER
T7   GND   GND
U10   VCC   POWER
U11   GND   GND
U12   VCC   POWER
U13   GND   GND
U14   VCC   POWER
U15   GND   GND
U16   VCC_HPS   POWER
U17   GND   GND
U18   VCC_HPS   POWER
U19   VCCIO6B_HPS   POWER
U21   VCC   POWER
U22   GND   GND
U23   VCCPD5B   POWER
U24   GND   GND
U29   GND   GND
U3   GND   GND
U4   GND   GND
U5   VCCE_GXBL   POWER
U6   GND   GND
U9   GND   GND
V1   GND   GND
V10   GND   GND
V11   VCC   POWER
V12   GND   GND
V13   VCC   POWER
V14   GND   GND
V15   VCC   POWER
V16   SS[1][1]   25_crpio_r50
V17   SS[1][6]   25_crpio_r50
V18   SS[0][1]   25_crpio_r50
V19   GND   GND
V2   GND   GND
V21   GND   GND
V22   VCCPD5A   POWER
V24   VCCPD5A   POWER
V25   SW[5]   25_rrnin
V26   VCCIO6B_HPS   POWER
V5   GND   GND
V6   VCCH_GXBL   POWER
V7   GND   GND
V8   VCCA_FPLL   POWER
W10   VCC   POWER
W11   GND   GND
W12   VCC   POWER
W13   GND   GND
W14   VCC   POWER
W15   MSEL[0]   25_crpin
W16   SS[2][6]   25_crnio_r50
W17   SS[0][0]   25_crnio_r50
W18   GND   GND
W19   SS[3][1]   25_crnio_r50
W23   VCCIO5A   POWER
W25   SW[4]   25_rrpin
W28   GND   GND
W3   GND   GND
W4   GND   GND
W5   VCCL_GXBL   POWER
W6   GND   GND
W9   GND   GND
Y1   GND   GND
Y10   GND   GND
Y11   VCC   POWER
Y12   GND   GND
Y13   VCC   POWER
Y14   GND   GND
Y15   GND   GND
Y16   MSEL[2]   25_crnin
Y17   SS[2][3]   25_crpio_r50
Y18   SS[2][4]   25_crpio_r50
Y19   SS[3][0]   25_crpio_r50
Y2   GND   GND
Y20   GND   GND
Y22   VCCA_FPLL   POWER
Y25   GND   GND
Y27   SW[1]   25_rrnin
Y30   GND   GND
Y5   GND   GND
Y6   VCCE_GXBL   POWER
Y7   GND   GND
Y8   GND   GND
Y9   VCC   POWER
| Models and submodels in the file (14): 25_crnin (Input), 25_crnio_r50 (I/O), 25_crpin (Input), 25_crpio_r50 (I/O), 25_ctnin (Input), 25_ctnio_r50 (I/O), 25_ctpin (Input), 25_ctpio_r50 (I/O), 25_rrnin (Input), 25_rrnio_r50 (I/O), 25_rrpin (Input), 25_rrpio_r50 (I/O), 25_rtnin (Input), 25_rtpin (Input)
